* M3b.1 rev B; generated pin interconnect. Models are project behavioral approximations.
* ARM_BUTTON models the field-side dry-contact stimulus: open/0 when released, V5_F when pressed.
.subckt frontend USB5V GND_L D3 D8 ECU_DATA GND_F BAT_PLUS ARM_BUTTON
XU1 GND_L NC_U1_2 USB5V D8 D3 NC_U1_6 GND_L NC_U1_8 GND_F NC_U1_10 NC_U1_11 TX_F RX_F V5_F NC_U1_15 GND_F ISO7721F_PROJECT
XU2 NC_U2_1 TX_ALLOWED GND_F GATE_DRIVE V5_F LVC17_PROJECT
XU3 RX_F VREF SENSE GND_F GND_F VREF NC_U3_7 V5_F LM393B_PROJECT
Vfield_fixture V5_F GND_F 5
XQ1 GATE SINK_RET DRAIN PMV88_PROJECT
XQ2 PG_GATE GND_F SINK_RET PMV88_PG_PROJECT
XU5 TX_F GND_F TIMER_SET TIMER_DIV V5_F TIMEOUT LTC6994_1_PROJECT
XU6 ARM_RAW GND_F ARM_SET ARM_DIV V5_F ARM_CLK LTC6994_2_PROJECT
XU7 ARM_CLK ARM_DATA LOCKED GND_F ARMED CLR_N V5_F V5_F LVC74_PROJECT
XU8 TX_F TIMEOUT CLR_N GND_F TIMEOUT POWER_BAD IDLE_OK V5_F LVC2NOR_PROJECT
XU9 TX_F ARMED ARM_SAFE GND_F IDLE_OK PG_CLEAN TX_ALLOWED V5_F LVC2AND_PROJECT
XU10 NC_U10_1 PG_CLEAN GND_F NOT_PG V5_F LVCINV_PROJECT
XU11 PG_F GND_F V5_F NC_U11_CT PG_SENSE_F V5_F TPS3808_PROJECT
XU12 NC_U12_1 PG_F GND_F PG_CLEAN V5_F LVC17_PROJECT
XU13 PG_L GND_L USB5V NC_U13_CT PG_SENSE_L USB5V TPS3808_PROJECT
XQ3 PG_LED_GATE GND_L LED_K PMV88_LED_PROJECT
XU14 LED_A LED_K GND_F USB_BAD VO617_PROJECT
XU15 NOT_PG USB_BAD_CLEAN GND_F POWER_BAD V5_F LVCOR_PROJECT
XU16 NC_U16_1 USB_BAD GND_F USB_BAD_CLEAN V5_F LVC17_PROJECT
XU17 READY_REQ GND_F READY_SET READY_DIV V5_F READY_QUAL LTC6994_READY_PROJECT
XU18 READY_QUAL V5_F NC_U18_3 GND_F REARM_READY CLR_N V5_F V5_F LVC74_PROJECT
XU19 ARM_RAW_CLEAN POWER_BAD NC_U19_3 GND_F V5_F V5_F RELEASE_OK V5_F LVC2NOR_PROJECT
XU20 RELEASE_OK IDLE_OK ARM_DATA GND_F ARM_SAFE REARM_READY READY_REQ V5_F LVC2AND_PROJECT
XU21 NC_U21_1 ARM_RAW GND_F ARM_RAW_CLEAN V5_F LVC17_PROJECT
D1 GND_F DRAIN SS16_PROJECT
D2 GND_F SENSE BAT54_PROJECT
D3P BAT_LIMITED LDO_IN SS16_PROJECT
R1 ECU_DATA SENSE 222200.0
R2 SENSE GND_F 67320.0
R3 RX_F SENSE 990000.0
R4 V5_F VREF 78700
R5 VREF GND_F 10100.0
R6 V5_F RX_F 2200
R7 GATE_DRIVE GATE 220
R8 GATE GND_F 68000
R9 D3 GND_L 47000
R10 D8 GND_L 10000
R11 V5_F GND_F 1000
R12 ECU_DATA TX_MID 22
R13 TX_MID DRAIN 22
R14 BAT_PLUS BAT_LIMITED 47
R15 TIMER_SET GND_F 200000
R16 V5_F TIMER_DIV 357000
R17 TIMER_DIV GND_F 100000
R18 ARM_SET GND_F 249000
R19 V5_F ARM_DIV 255000
R20 ARM_DIV GND_F 100000
R21 V5_F PG_F 150000
R22 ARM_RAW GND_F 10000
R23 ARM_BUTTON ARM_RAW 1000
R24 PG_F PG_GATE 2200
R25 PG_GATE GND_F 10000000
R26 USB5V PG_L 150000
R27 USB5V LED_A 390
R28 V5_F USB_BAD 10000
R29 V5_F PG_SENSE_F 100000
R30 PG_SENSE_F GND_F 10200
R31 USB5V PG_SENSE_L 100000
R32 PG_SENSE_L GND_L 10200
R33 READY_SET GND_F 249000
R34 V5_F READY_DIV 255000
R35 READY_DIV GND_F 100000
R36 PG_L PG_LED_GATE 2200
C1 USB5V GND_L 1e-07
C2 V5_F GND_F 1e-07
C3 V5_F GND_F 1e-07
C4 V5_F GND_F 1e-07
C5 VREF GND_F 1e-08
C6 LDO_IN GND_F 2.2e-06
C7 V5_F GND_F 2.2e-06
C8 V5_F GND_F 2.2e-06
C9 V5_F GND_F 2.2e-06
C10 GATE GND_F 2.2e-09
C11 PG_GATE GND_F 2.2e-09
C12 V5_F GND_F 1e-07
C13 V5_F GND_F 1e-07
C14 V5_F GND_F 1e-07
C15 V5_F GND_F 1e-07
C16 V5_F GND_F 1e-07
C17 V5_F GND_F 1e-07
C18 V5_F GND_F 1e-07
C19 V5_F GND_F 1e-07
C20 USB5V GND_L 1e-07
C21 V5_F GND_F 1e-07
C22 V5_F GND_F 1e-07
C23 V5_F GND_F 1e-07
C24 V5_F GND_F 1e-07
C25 V5_F GND_F 1e-07
C26 V5_F GND_F 1e-07
C27 V5_F GND_F 1e-07
.ends frontend
