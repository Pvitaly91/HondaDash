* M3b rev A; generated pin interconnect. Models are project behavioral approximations.
.subckt frontend USB5V GND_L D3 D8 ECU_DATA GND_F BAT_PLUS
XU1 GND_L NC_U1_2 USB5V D8 D3 NC_U1_6 GND_L NC_U1_8 GND_F NC_U1_10 NC_U1_11 TX_F RX_F V5_F NC_U1_15 GND_F ISO7721F_PROJECT
XU2 NC_U2_1 TX_F GND_F GATE_DRIVE V5_F LVC17_PROJECT
XU3 RX_F VREF SENSE GND_F GND_F VREF NC_U3_7 V5_F LM393B_PROJECT
XU4 LDO_IN GND_F NC_U4_EN NC_U4_4 V5_F TPS709_PROJECT
XQ1 GATE GND_F DRAIN PMV88_PROJECT
D1 GND_F DRAIN SS16_PROJECT
D2 GND_F SENSE BAT54_PROJECT
D3P BAT_LIMITED LDO_IN SS16_PROJECT
R1 ECU_DATA SENSE 220000
R2 SENSE GND_F 68000
R3 RX_F SENSE 1000000
R4 V5_F VREF 78700
R5 VREF GND_F 10000
R6 V5_F RX_F 2200
R7 GATE_DRIVE GATE 100
R8 GATE GND_F 68000
R9 D3 GND_L 47000
R10 D8 GND_L 10000
R11 V5_F GND_F 1000
R12 ECU_DATA TX_MID 22
R13 TX_MID DRAIN 22
R14 BAT_PLUS BAT_LIMITED 47
C1 USB5V GND_L 1e-07
C2 V5_F GND_F 1e-07
C3 V5_F GND_F 1e-07
C4 V5_F GND_F 1e-07
C5 VREF GND_F 1e-08
C6 LDO_IN GND_F 2.2e-06
C7 V5_F GND_F 2.2e-06
C8 V5_F GND_F 2.2e-06
C9 V5_F GND_F 2.2e-06
C10 GATE GND_F 2.2e-09
.ends frontend
