* ORIGINAL PROJECT MODELS, not manufacturer models. See MODEL_LIMITS.md.
* These are finite-impedance electrical approximations; no avalanche, thermal,
* insulation breakdown, or hidden ideal surge clamp. Time is seconds.
.options method=gear
.param CMP_DELAY=1u CMP_OFFSET=0 RX_LEAK=0 Q_RON=.32 TX_LEAK=200u
.param SENSE_EXTRA_C=10p CGD=50p CGS=200p FIELD_SET=5
.param ISO_DELAY=17n
.param RT_SCALE=1 RB_SCALE=1 RF_SCALE=1 VREF_SCALE=1
.param TIMER_SCALE=1 TIMER_BYPASS=0 ARM_UNSAFE=0 GATE_REVERSED=0 PG_BYPASS=0
.param PG_DELAY=20m PG_THRESHOLD=.405 PG_HYST=.03 PG_FAIL_DELAY=50u
.param DEBOUNCE_SCALE=1 LOGIC_DELAY=5n OPTO_DELAY=50u OPTO_CTR=.8
.param LOW_POWER_TX=1 LOW_POWER_RX=1 QPG_RON=.5
.param Q1_OFF_LEAK=1u Q2_OFF_LEAK=1u
.param CLAMP_LEAK=2u
.param HOLD_CAP=9.4u HOLD_BLOCK_DELAY=15u HOLD_ON_DELAY=150u
.param HOLD_EXTRA_LOAD=6.2m HOLD_BYPASS=0 HOLD_RON=.14 HOLD_LEAK=2.7u
.param COUNTER_K=1.1507282898071236
* Smooth normalized counter: dc/dt=(K/T)*(1-c/4). It crosses c=1
* at exactly T because K=4*ln(4/3), and approaches4 without a hard clamp.
* A discontinuous c<1.02 current cutoff plus Roff leakage creates numerical
* chatter at tight tolerances; that internal implementation is not hardware.
.model SS16_PROJECT D(Is=10n N=1.5 Rs=.02 Bv=60 Ibv=1m)
.model BAT54_PROJECT D(Is=10n N=1 Rs=1 Bv=30 Ibv=100u Cjo=10p)
.model QSW SW(Ron={Q_RON} Roff=1e12 Vt=2.3 Vh=0)
.model CMP_SW SW(Ron=160 Roff=1e12 Vt=2.5 Vh=0)
.model PWR_SW SW(Ron=2 Roff=1e12 Vt=5.8 Vh=.05)

.subckt ISO7721F_PROJECT g1 n2 v1 outa inb n6 g7 n8 g9 n10 n11 outb ina v2 n15 g16
* Both supplies required. Default LOW; no galvanic resistive path across barrier.
* RC 50% delay=17ns, not a transport model at GHz. Aggregate numerical bound 0.3us.
Btx itx g9 V=V(v2,g9)*((V(v2,g9)>=2.25) ? ((V(v1,g1)>=2.25) ? (V(inb,g1)>2) : ((V(v1,g1)<=1.7) ? 0 : {LOW_POWER_TX})) : {LOW_POWER_TX})
Rtx itx outb 50
Ctx outb g9 {ISO_DELAY/(50*.69314718056)}
Brx irx g1 V=V(v1,g1)*((V(v1,g1)>=2.25) ? ((V(v2,g9)>=2.25) ? (V(ina,g9)>2) : ((V(v2,g9)<=1.7) ? 0 : {LOW_POWER_RX})) : {LOW_POWER_RX})
Rrx irx outa 50
Crx outa g1 {ISO_DELAY/(50*.69314718056)}
Riq1 v1 g1 2000
Riq2 v2 g9 2000
* Cross-barrier capacitance allocation, not guaranteed production capacitance.
Cbar g1 g9 2p
.ends

.subckt BAT54_CLAMP_PROJECT anode nc cathode
* Original rail-clamp model. BAT54 pin1=A, pin2=NC, pin3=K.
* Finite diode plus explicit 2uA reverse allocation. The source datasheet's
* VF/leakage values are 25C short-pulse conditions; full DC/temp stays OPEN.
Dforward anode cathode BAT54_PROJECT
Bleak cathode anode I={CLAMP_LEAK}*min(max(V(cathode,anode),0),1)
.ends

.subckt SS16_DRAIN_PROJECT anode cathode
* Dominant DATA off leakage belongs to D1 cathode-to-GND, not Q1 D-to-S.
* TX_LEAK remains the 0..200uA D1 allocation used by the existing corners.
Dforward anode cathode SS16_PROJECT
Bleak cathode anode I={TX_LEAK}*min(max(V(cathode,anode),0),1)
.ends

.subckt LM66100_PROJECT vin g ce nc status out
* CE is held downstream V5_L, VIN is DIRECT raw USB. The 22R feed is
* downstream of OUT; putting it ahead of VIN can mask the 80mV off test.
* Finite original model, not TI model. Full-temp ON/OFF CE limits used;
* switching times and low-load Ron are explicit measured allocations.
Cmemory memory g 1p IC=0
Bkeeper g memory I=((V(memory,g)>.5) ? (1-V(memory,g)) : -V(memory,g))/1e6
Bone one g V=1
Bon set g V=((V(vin,g)>=1.5)&&(V(ce,g)<V(vin,g)-.25)) ? 5 : 0
Boff clear g V=(V(ce,g)>V(vin,g)+.08) ? 5 : 0
Sset one memory set g HOLD_STATE
Sclear memory g clear g HOLD_STATE
.model HOLD_STATE SW(Ron=100 Roff=1e12 Vt=2.5 Vh=0)
Brequest request g V=(V(memory,g)>.5) ? 1 : 0
Adel_on %vd(request g) %vd(delay_on g) null HOLD_ON
.model HOLD_ON delay(delay={HOLD_ON_DELAY} buffer_size=8192)
Adel_off %vd(request g) %vd(delay_off g) null HOLD_OFF
.model HOLD_OFF delay(delay={HOLD_BLOCK_DELAY} buffer_size=8192)
Bchannel control g V=({HOLD_BYPASS}>.5) ? 5 : 5*((V(request,g)>.5) ? (V(delay_on,g)>.5) : (V(delay_off,g)>.5))
Schannel vin out control g HOLD_CHANNEL
.model HOLD_CHANNEL SW(Ron={HOLD_RON} Roff=1e12 Vt=2.5 Vh=0)
* Passive finite forward diode exists even when channel is OFF. This is a
* nominal body diode equation, not a guaranteed max across all temperatures.
Dbody vin out HOLD_BODY
.model HOLD_BODY D(Is=1n N=1.2 Rs=.1 Bv=6)
* Datasheet-backed worst off leakage for <=5.5V reverse and -40..85C.
Bleak out vin I={HOLD_LEAK}*min(max(V(out,vin),0),1)
Biq vin g I=(V(vin,g)>1.5) ? .3u : 0
Bce ce g I=(V(ce,g)>V(vin,g)+.08) ? .61u : .3u
* Aggregate additional-load allocation complements the 2k ISO Iq model.
* The physical total-current gate is <=10mA including both10k pullups,
* buffers, reset and parasitics. This allocation is not a physical resistor;
* ideal behavioral voltage outputs do not model conversion efficiency.
* The old constant-current jump at0V could have no operating point during
* a slow body-diode-fed USB ramp. For undefined partial power use C1 smoothstep
* u*u*(3-2*u), u=clip(VCE/1V,0,1). Full load is EXACTLY unchanged above1V,
* including every valid >=2.25V hold state. Low-voltage law is an allocation.
Bload ce g I={HOLD_EXTRA_LOAD}*min(max(V(ce,g),0),1)*min(max(V(ce,g),0),1)*(3-2*min(max(V(ce,g),0),1))
.ends

.subckt LVC17_PROJECT nc a g y vcc
Bdrive drv g V=(V(vcc,g)>=1.65) ? max(V(vcc,g)-.1,0)*(V(a,g)>.5*V(vcc,g)) : V(vcc,g)*{LOW_POWER_TX}
* Driven LOW while powered; high impedance after power loss.
Boutput y g I=(V(vcc,g)>.1) ? (V(y,g)-V(drv,g))/20 : V(y,g)/1e12
* Worst positive powered-off leakage allocation flows from local rail only.
Bleak vcc y I=(V(vcc,g)<.8) ? 10u : 0
Biq vcc g I=(V(vcc,g)>1) ? 10u : 0
.ends

.subckt LTC6994_READY_PROJECT in g set div vcc out
Bset set g V=(V(vcc,g)>2.25) ? 1 : 0
Ccount count g 1n IC=0
Bcount g count I=((V(vcc,g)>=2.25)&&(V(in,g)>.5*V(vcc,g))) ? 1n*50000*abs(I(Bset))/(4096u*{DEBOUNCE_SCALE})*{COUNTER_K}*max(1-V(count,g)/4,0) : 0
Breset reset g V=((V(in,g)<.5*V(vcc,g))||(V(vcc,g)<2.25)) ? 5 : 0
Sreset count g reset g READY_RESET
.model READY_RESET SW(Ron=100 Roff=1e12 Vt=2.5 Vh=0)
Bdrive drv g V=V(vcc,g)*((V(count,g)>=1)&&(V(div,g)>=.26625*V(vcc,g))&&(V(div,g)<=.29625*V(vcc,g)))
Rout drv out 50
Cout out g 10p
Biq vcc g I=(V(vcc,g)>2.25) ? 175u : 0
.ends

.subckt PMV88_LED_PROJECT gate source drain
* Health-LED MOS leakage kept separate from DATA-path 200uA allocation.
Bmos drain source I=V(drain,source)*(1e-12+1/({Q_RON}*(1+exp(max(min((2.3-V(gate,source))/.08,40),-40)))))
Cgd_i gate drain {CGD}
Cgs_i gate source {CGS}
Dbody source drain BODY_LED_PROJECT
.model BODY_LED_PROJECT D(Is=1n N=1.8 Rs=.15 Bv=60)
Bleak drain source I=5u*min(max(V(drain,source),0),1)
.ends

.subckt PMV88_PG_PROJECT gate source drain
* Q2 at minimum static PG voltage (~3.7V) lacks a guaranteed Rds table entry.
* .5ohm is a measured-acceptance allocation, deliberately separate from Q1.
Bmos drain source I=V(drain,source)*(1e-12+1/({QPG_RON}*(1+exp(max(min((2.3-V(gate,source))/.08,40),-40)))))
Cgd_i gate drain {CGD}
Cgs_i gate source {CGS}
Dbody source drain BODY_PG_PROJECT
.model BODY_PG_PROJECT D(Is=1n N=1.8 Rs=.15 Bv=60)
Bleak drain source I={Q2_OFF_LEAK}*min(max(V(drain,source),0),1)
.ends

* Each new IC below has finite output resistance, load and state storage.
* Counters represent timer digital state, not a substituted RC physical timer.
* Scaling is from external SET current; removing RSET removes timing.
.subckt LTC6994_1_PROJECT in g set div vcc out
Bset set g V=(V(vcc,g)>2.25) ? 1 : 0
Ccount count g 1n IC=0
Bcount g count I=((V(vcc,g)>=2.25)&&(V(in,g)>.5*V(vcc,g))) ? 1n*50000*abs(I(Bset))/(512u*{TIMER_SCALE})*{COUNTER_K}*max(1-V(count,g)/4,0) : 0
Breset reset g V=((V(in,g)<.5*V(vcc,g))||(V(vcc,g)<2.25)) ? 5 : 0
Sreset count g reset g TIMER_RESET
.model TIMER_RESET SW(Ron=100 Roff=1e12 Vt=2.5 Vh=0)
* Incorrect DIV code forces fault, so omission cannot silently preserve timing.
Bdrive drv g V=V(vcc,g)*(({TIMER_BYPASS}>.5) ? 0 : ((V(count,g)>=1)||(V(div,g)<.20375*V(vcc,g))||(V(div,g)>.23375*V(vcc,g))))
Rout drv out 50
Cout out g 10p
Biq vcc g I=(V(vcc,g)>2.25) ? 175u : 0
.ends

.subckt LTC6994_2_PROJECT in g set div vcc out
Bset set g V=(V(vcc,g)>2.25) ? 1 : 0
Chi high g 1n IC=0
Clo low g 1n IC=0
Bhi g high I=((V(vcc,g)>=2.25)&&(V(in,g)>.5*V(vcc,g))) ? 1n*50000*abs(I(Bset))/(4096u*{DEBOUNCE_SCALE})*{COUNTER_K}*max(1-V(high,g)/4,0) : 0
Blo g low I=((V(vcc,g)>=2.25)&&(V(in,g)<.5*V(vcc,g))) ? 1n*50000*abs(I(Bset))/(4096u*{DEBOUNCE_SCALE})*{COUNTER_K}*max(1-V(low,g)/4,0) : 0
Bhreset hr g V=((V(in,g)<.5*V(vcc,g))||(V(vcc,g)<2.25)) ? 5 : 0
Blreset lr g V=((V(in,g)>.5*V(vcc,g))||(V(vcc,g)<2.25)) ? 5 : 0
Shr high g hr g DEB_RESET
Slr low g lr g DEB_RESET
.model DEB_RESET SW(Ron=100 Roff=1e12 Vt=2.5 Vh=0)
Cstate state g 1p IC=0
Bkeeper g state I=((V(state,g)>.5) ? (1-V(state,g)) : -V(state,g))/1e6
Bsetstate ss g V=(V(high,g)>=1) ? 5 : 0
Bclrstate cs g V=((V(low,g)>=1)||(V(vcc,g)<2.25)) ? 5 : 0
Bone one g V=1
Sset one state ss g DEB_STATE
Sclr state g cs g DEB_STATE
.model DEB_STATE SW(Ron=100 Roff=1e12 Vt=2.5 Vh=0)
Bdrive drv g V=V(vcc,g)*(V(state,g)>.5)
Rout drv out 50
Cout out g 10p
Biq vcc g I=(V(vcc,g)>2.25) ? 175u : 0
.ends

.subckt LVC74_PROJECT clk d qb g q clr pre vcc
* Delayed clock creates a finite aperture for the actual rising-edge sample.
Rclk clk clkdel 50
Cclk clkdel g {10n/(50*.69314718056)}
Bclocklogic clocklogic g V=(V(clk,g)>.5*V(vcc,g)) ? 1 : 0
* Differentiate normalized clock state, not the analog HIGH level: rail ripple
* must not become a new clock edge. The Boolean state changes only at crossing.
Baperture aperture g V=((V(clocklogic,g)>.5)&&(ddt(V(clocklogic,g))>1e4)&&(V(vcc,g)>=1.65)) ? 5 : 0
Bd data g V=({ARM_UNSAFE}>.5) ? 1 : (V(d,g)>.5*V(vcc,g))
Cstate state g 1p IC=0
Bkeeper g state I=((V(state,g)>.5) ? (1-V(state,g)) : -V(state,g))/1e6
Scapture data state aperture g LATCH_SW
Bclear clearing g V=((V(clr,g)<.5*V(vcc,g))&&(V(vcc,g)>=1.65)) ? 5 : 0
Sclear state g clearing g LATCH_SW
* Undefined supply is adversarial state=1, not a fictitious guaranteed reset.
Bone one g V=1
Bunknown unknown g V=(V(vcc,g)<1.65) ? 5 : 0
Sunknown one state unknown g LATCH_SW
.model LATCH_SW SW(Ron=100 Roff=1e12 Vt=2.5 Vh=0)
Bq drv g V=(V(vcc,g)>=1.65) ? V(vcc,g)*(V(state,g)>.5) : V(vcc,g)*{LOW_POWER_TX}
Bqb drvb g V=V(vcc,g)*(V(state,g)<.5)
Rq drv q 50
Cq q g {LOGIC_DELAY/(50*.69314718056)}
Rqb drvb qb 50
Biq vcc g I=(V(vcc,g)>1.65) ? 10u : 0
.ends

.subckt LVC2NOR_PROJECT a b y2 g c d y1 vcc
B1 drv1 g V=(V(vcc,g)>=1.65) ? V(vcc,g)*((V(a,g)<.5*V(vcc,g))&&(V(b,g)<.5*V(vcc,g))) : V(vcc,g)*{LOW_POWER_TX}
B2 drv2 g V=(V(vcc,g)>=1.65) ? V(vcc,g)*((V(c,g)<.5*V(vcc,g))&&(V(d,g)<.5*V(vcc,g))) : V(vcc,g)*{LOW_POWER_TX}
R1 drv1 y1 50
R2 drv2 y2 50
C1 y1 g {LOGIC_DELAY/(50*.69314718056)}
C2 y2 g {LOGIC_DELAY/(50*.69314718056)}
Biq vcc g I=(V(vcc,g)>1.65) ? 10u : 0
.ends

.subckt LVC2AND_PROJECT a b y2 g c d y1 vcc
B1 drv1 g V=(V(vcc,g)>=1.65) ? V(vcc,g)*(({GATE_REVERSED}>.5) ? (V(a,g)<.5*V(vcc,g)) : ((V(a,g)>.5*V(vcc,g))&&(V(b,g)>.5*V(vcc,g)))) : V(vcc,g)*{LOW_POWER_TX}
B2 drv2 g V=(V(vcc,g)>=1.65) ? V(vcc,g)*((V(c,g)>.5*V(vcc,g))&&(V(d,g)>.5*V(vcc,g))) : V(vcc,g)*{LOW_POWER_TX}
R1 drv1 y1 50
R2 drv2 y2 50
C1 y1 g {LOGIC_DELAY/(50*.69314718056)}
C2 y2 g {LOGIC_DELAY/(50*.69314718056)}
Biq vcc g I=(V(vcc,g)>1.65) ? 10u : 0
.ends

.subckt LVCINV_PROJECT nc a g y vcc
Bdrive drv g V=(V(vcc,g)>=1.65) ? V(vcc,g)*(V(a,g)<.5*V(vcc,g)) : V(vcc,g)*{LOW_POWER_TX}
Rout drv y 50
Cout y g {LOGIC_DELAY/(50*.69314718056)}
Biq vcc g I=(V(vcc,g)>1.65) ? 10u : 0
.ends

.subckt LVCOR_PROJECT a b g y vcc
Bdrive drv g V=(V(vcc,g)>=1.65) ? V(vcc,g)*((V(a,g)>.5*V(vcc,g))||(V(b,g)>.5*V(vcc,g))) : V(vcc,g)*{LOW_POWER_TX}
Rout drv y 50
Cout y g {LOGIC_DELAY/(50*.69314718056)}
Biq vcc g I=(V(vcc,g)>1.65) ? 10u : 0
.ends

.subckt TPS3808_PROJECT reset g mr ct sense vcc
Cstable stable g 1n IC=0
Bstable g stable I=((V(vcc,g)>1.7)&&(V(sense,g)>{PG_THRESHOLD}*(1+{PG_HYST}))) ? 1n/{PG_DELAY}*{COUNTER_K}*max(1-V(stable,g)/4,0) : 0
Bunstable unstable g V=((V(sense,g)<{PG_THRESHOLD})||(V(vcc,g)<1.7)) ? 5 : 0
Srestart stable g unstable g PG_RESET
.model PG_RESET SW(Ron=100 Roff=1e12 Vt=2.5 Vh=0)
* Release requires the full stable timer. Invalid <.8V RESET is high impedance;
* only local pullup/Miller can raise gate. Do not assert a correct logic LOW there.
Bstate asserted g V=(({PG_BYPASS}>.5) ? 0 : ((V(stable,g)<1)||(V(vcc,g)<1.7))) ? 5 : 0
Aassert %vd(asserted g) %vd(delayed g) null DELAY_PG
.model DELAY_PG delay(delay={PG_FAIL_DELAY} buffer_size=8192)
Breset reset g I=(V(vcc,g)>=.8) ? ((V(delayed,g)>2.5) ? V(reset,g)/100 : V(reset,g)/1e12) : V(reset,g)/1e12
Biq vcc g I=(V(vcc,g)>1.7) ? 6u : 0
.ends

.subckt VO617_PROJECT anode cathode emitter collector
Dled anode cathode OPTO_LED
.model OPTO_LED D(Is=1f N=1.5 Rs=5)
* Analog light current drives finite collector conductance after bounded storage.
Blight light emitter V=max(I(Dled),0)
Alight %vd(light emitter) %vd(delayed emitter) null DELAY_OPTO
.model DELAY_OPTO delay(delay={OPTO_DELAY} buffer_size=8192)
Bcollector collector emitter I=V(collector,emitter)/(1e9+1/1e-9) + min(max(V(collector,emitter)/100,0),max(V(delayed,emitter),0)*{OPTO_CTR})
Cce collector emitter 10p
Cbar anode emitter 1p
.ends

.subckt PMV88_PROJECT gate source drain
* Smooth finite conductance avoids an ideal switch + Miller capacitance numerical
* discontinuity. This transition is an allocation, not a fitted MOSFET model.
Bmos drain source I=V(drain,source)*(1e-12+1/({Q_RON}*(1+exp(max(min((2.3-V(gate,source))/.08,40),-40)))))
Cgd_i gate drain {CGD}
Cgs_i gate source {CGS}
* Body diode is secondary to D1; use a separate finite diode equation.
Dbody source drain BODY_PROJECT
.model BODY_PROJECT D(Is=1n N=1.8 Rs=.15 Bv=60)
* Q1/Q2 IDSS source condition: 1uA at60V,VGS0,25C. Full temp/off-state OPEN.
* Q1_OFF_LEAK=200u is an explicit adverse sensitivity, not manufacturer max.
Bleak drain source I={Q1_OFF_LEAK}*min(max(V(drain,source),0),1)
.ends

.subckt LM393B_PROJECT out minus plus g plus2 minus2 out2 vcc
Bdecision decision g V=(V(plus,g)>V(minus,g)+{CMP_OFFSET}) ? 0 : 5
* ngspice42 built-in analog delay: bounded ring buffer, differential ports.
* Runtime loads the packaged analog.cm before parsing this original model.
Adelay %vd(decision g) %vd(delayed g) null DELAY_CMP
.model DELAY_CMP delay(delay={CMP_DELAY} buffer_size=8192)
* Output saturation bounded by 160 ohms: <.4V at the actual 2.4mA pullup.
Bcontrol control g V=(V(vcc,g)>2) ? V(delayed,g) : 0
Sout out g control g CMP_SW
Rspare out2 g 160
Isense plus g {RX_LEAK}
Csense plus g {SENSE_EXTRA_C}
* Explicit assumed off-state injection, instead of asserting zero backfeed.
Boff plus vcc I=(V(vcc,g)<2) ? 10u*min(max(V(plus,g),0),1) : 0
Riq vcc g 6250
.ends

.subckt TPS709_PROJECT vin g en nc out
Breg ideal g V=max(min({FIELD_SET},V(vin,g)-.5),0)
Spower ideal out vin g PWR_SW
* Input quiescent + conservative functional 20mA load allocation used for droop.
* Output power is NOT conserved by Breg; do not use this model for LDO efficiency.
Binput vin g I=(V(vin,g)>2) ? 20m : 0
.ends
